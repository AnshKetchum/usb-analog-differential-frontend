ADE simulation setup
Test rx_ams_afe_analogFrontendTestbench_1: rx_ams_afe/analogFrontendTestbench/schematic, simulator spectre
  Models: /home/ff/eecs251b/sky130/sky130_cds/sky130_release_0.0.3/libs/sky130_fd_pr_main/../../models/sky130.lib.spice[tt]
  Variables: rise = 100f; fclk = 2.4G; ACCESS_NMOS_L = 150n; ACCESS_NMOS_W = 420n; CCN_L = 150n; CCN_W = 420n; CCP_L = 150n; CCP_W = 550n; IP_L = 150n; IP_W = 550n; OP_L = 150n; OP_W = 550n; VDD = 3.3; VSS = 0; delay = 0.25/fclk
  Temperature: 27
  Analysis tran: stop=1n errpreset=moderate
  Signals: /D_out-, /D_out+, /D-, /D+, /clk, /VDD, /VSS
Run mode: Single Run, Sweeps and Corners
