ADE simulation setup
Run mode: Single Run, Sweeps and Corners
Tests:
  rx_ams_afe_analogFrontendTestbench_1: rx_ams_afe/analogFrontendTestbench/schematic, simulator spectre
    Variables: fclk = 2.4G; ACCESS_NMOS_L = 150n; ACCESS_NMOS_W = 420n; CCN_L = 150n; CCN_W = 420n; CCP_L = 150n; CCP_W = 550n; delay = 0.25/fclk; IP_L = 150n; IP_W = 550n; OP_L = 150n; OP_W = 550n; VDD = 3.3; VSS = 0; rise = 100f
