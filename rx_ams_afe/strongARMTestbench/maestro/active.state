ADE simulation setup
Test rx_ams_afe_strongARMTestbench_1: rx_ams_afe/strongARMTestbench/schematic, simulator spectre
  Models: /home/ff/eecs251b/sky130/sky130_cds/sky130_release_0.0.3/libs/sky130_fd_pr_main/../../models/sky130.lib.spice[tt]
  Variables: ACCESS_NMOS_L = 150n; ACCESS_NMOS_W = 420n; CCN_L = 150n; CCN_W = 420n; CCP_L = 150n; CCP_W = 550n; IP_L = 150n; IP_W = 550n; OP_L = 150n; OP_W = 550n; fclk = 10K; VDD = 3.3; VSS = 0; delay = 0.25/fclk
  Temperature: 27
  Analysis tran: stop=500/VAR("fclk") errpreset=moderate
  Output t_conv_plus = delayMeasure(VT("/D+") VT("/D_out+") ?edge1 "rising" ?edge2 "falling") (unticked)
  Output t_conv_minus = delayMeasure(VT("/D-") VT("/D_out-") ?edge1 "rising" ?edge2 "falling") (unticked)
  Signals: /D_out-, /D_out+, /D+, /D-, /clk, /I0/net3, /VSS, /I0/net2, /I0/net1
Run mode: Single Run, Sweeps and Corners
Setup values for test rx_ams_afe_strongARMTestbench_1: fclk = 2.4G; ACCESS_NMOS_LENGTH = 150n; ACCESS_NMOS_WIDTH = 420n; CROSS_COUPLED_NMOS_LENGTH = 150n; CROSS_COUPLED_NMOS_WIDTH = 420n; CROSS_COUPLED_PMOS_LENGTH = 150n; CROSS_COUPLED_PMOS_WIDTH = 800n; INNER_PRECHARGE_LENGTH = 150n; INNER_PRECHARGE_WIDTH = 550n; OUTER_PRECHARGE_LENGTH = 150n; OUTER_PRECHARGE_WIDTH = 550n
