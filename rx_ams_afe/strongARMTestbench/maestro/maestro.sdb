ADE simulation setup
Run mode: Single Run, Sweeps and Corners
Tests:
  rx_ams_afe_strongARMTestbench_1: rx_ams_afe/strongARMTestbench/schematic, simulator spectre
    Variables: fclk = 10K; delay = 0.25/fclk; VDD = 3.3; VSS = 0; ACCESS_NMOS_L = 150n; ACCESS_NMOS_W = 420n; CCN_L = 150n; CCN_W = 420n; CCP_L = 150n; CCP_W = 550n; IP_L = 150n; IP_W = 550n; OP_L = 150n; OP_W = 550n
    Outputs: t_conv_plus; t_conv_minus
