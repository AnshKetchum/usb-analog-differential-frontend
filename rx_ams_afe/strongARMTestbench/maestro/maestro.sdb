ADE simulation setup
Run mode: Single Run, Sweeps and Corners
Tests:
  rx_ams_afe_strongARMTestbench_1: rx_ams_afe/strongARMTestbench/schematic, simulator spectre
    Variables: fclk = 2.4G; delay = 0; VDD = 3.3; VSS = 0
    Outputs: t_conv_plus; t_conv_minus
