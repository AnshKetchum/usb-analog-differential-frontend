ADE simulation setup
Run mode: Single Run, Sweeps and Corners
Tests:
  rx_ams_afe_strongARMTestbench_1: rx_ams_afe/strongARMTestbench/schematic, simulator spectre
    Variables: fclk = 2.4G; delay = 0.25/fclk; VDD = 3.3; VSS = 0; ACCESS_NMOS_LENGTH = 150n; ACCESS_NMOS_WIDTH = 420n; CROSS_COUPLED_NMOS_LENGTH = 150n; CROSS_COUPLED_NMOS_WIDTH = 420n; CROSS_COUPLED_PMOS_LENGTH = 150n; CROSS_COUPLED_PMOS_WIDTH = 800n; INNER_PRECHARGE_LENGTH = 150n; INNER_PRECHARGE_WIDTH = 550n; OUTER_PRECHARGE_LENGTH = 150n; OUTER_PRECHARGE_WIDTH = 550n
    Outputs: t_conv_plus; t_conv_minus
