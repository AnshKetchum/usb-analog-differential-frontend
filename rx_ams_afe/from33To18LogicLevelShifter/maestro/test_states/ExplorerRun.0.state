ADE simulation setup
Test rx_ams_afe_from33To12LogicLevelShifter_1: rx_ams_afe/from33To12LogicLevelShifter/schematic, simulator spectre
  Models: /home/ff/eecs251b/sky130/sky130_cds/sky130_release_0.0.3/libs/sky130_fd_pr_main/../../models/sky130.lib.spice[tt]
  Variables: VIN = 3.3
  Temperature: 27
  Analysis dc: sweep VIN start=1.0 stop=4.0 lin=100
  Signals: /OUT as VOUT
