ADE simulation setup
Test rx_ams_afe_from33To12LogicLevelShifter_1: rx_ams_afe/from33To18LogicLevelShifter/schematic, simulator spectre
  Models: /home/ff/eecs251b/sky130/sky130_cds/sky130_release_0.0.3/libs/sky130_fd_pr_main/../../models/sky130.lib.spice[tt]
  Variables: VIN = 3.3
  Temperature: 27
  Signals: /OUT as VOUT
Run mode: Single Run, Sweeps and Corners
