ADE simulation setup
Run mode: Single Run, Sweeps and Corners
Tests:
  rx_ams_afe_from33To12LogicLevelShifter_1: rx_ams_afe/from33To18LogicLevelShifter/schematic, simulator spectre
    Variables: VIN = 3.3
