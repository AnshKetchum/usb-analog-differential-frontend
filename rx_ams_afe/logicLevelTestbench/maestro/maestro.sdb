ADE simulation setup
Run mode: Single Run, Sweeps and Corners
Tests:
  rx_ams_afe_from33To12LLTestbench_1: rx_ams_afe/logicLevelTestbench/schematic, simulator spectre
    Variables: VDD = 1.8
