ADE simulation setup
Run mode: Single Run, Sweeps and Corners
Tests:
  rx_ams_afe_afe_1: rx_ams_afe/afe/schematic, simulator spectre
