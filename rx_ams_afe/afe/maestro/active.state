ADE simulation setup
Test rx_ams_afe_afe_1: rx_ams_afe/afe/schematic, simulator spectre
  Models: /home/ff/eecs251b/sky130/sky130_cds/sky130_release_0.0.3/libs/sky130_fd_pr_main/../../models/sky130.lib.spice[tt]
  Temperature: 27
Run mode: Single Run, Sweeps and Corners
