ADE simulation setup
Run mode: Single Run, Sweeps and Corners
Tests:
  rx_ams_afe_from33To12LLTestbench_1: rx_ams_afe/from33To12LLTestbench/schematic, simulator spectre
    Variables: VDD = 1.2
