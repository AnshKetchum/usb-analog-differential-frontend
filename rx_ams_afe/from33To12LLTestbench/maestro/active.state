ADE simulation setup
Test rx_ams_afe_from33To12LLTestbench_1: rx_ams_afe/from33To12LLTestbench/schematic, simulator spectre
  Models: /home/ff/eecs251b/sky130/sky130_cds/sky130_release_0.0.3/libs/sky130_fd_pr_main/../../models/sky130.lib.spice[tt]
  Variables: VDD = 1.2
  Temperature: 27
  Analysis dc: sweep VDD start=1.2 stop=3.3 lin=101
  Signals: /VOUT
Run mode: Single Run, Sweeps and Corners
